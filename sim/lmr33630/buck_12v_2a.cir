* U uic
.include models/lmr33630a_ng.lib
VIN vin 0 20
CIN vin 0 10u
X1 0 boot en fb pg 0 sw vcc vin LMR33630A_TRANS
REN vin en 100k
CBOOT boot sw 100n
CVCC vcc 0 1u
RPG pg vcc 100k
L1 sw out 10u
COUT out 0 44u
RFBT out fb 100k
RFBB fb 0 9.09k
RLOAD out 0 6

.save v(out) i(L1) v(x1.u2_ss_int)
.tran 10n 6m 0 20n uic
.control
run
wrdata U2.txt v(out) i(L1) v(x1.u2_ss_int)
.endc
.end
